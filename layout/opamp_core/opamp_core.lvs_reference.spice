* Auto-generated by layout/opamp_core/lvs_reference.py -- DO NOT EDIT.
* Source of device sizes/nets: design/netlist/opamp_core.spice (via
* generate.PAIRS/generate.FOLDED, cross-checked at generation time).
* Source of the expansion (38 drawn units vs 9 schematic instances):
* generate.py's interdigitated matched arrays (unit + dummy columns)
* and folded multi-finger devices -- see lvs_reference.py's docstring
* for why options.combine_devices cannot close that gap here.
* Card shapes mirror klt's subckt-call converter (netlist_normalize).
M5_u0 tail ibias vss vss nfet L=0.52U W=1.1U
M5_u1 tail ibias vss vss nfet L=0.52U W=1.1U
Mbias_u0 ibias ibias vss vss nfet L=0.52U W=1.1U
Mbias_u1 ibias ibias vss vss nfet L=0.52U W=1.1U
Mtail_pair_dummy0 vss vss vss vss nfet L=0.52U W=1.1U
Mtail_pair_dummy1 vss vss vss vss nfet L=0.52U W=1.1U
M1_u0 d1 inn tail vss nfet L=0.13U W=1.6U
M1_u1 d1 inn tail vss nfet L=0.13U W=1.6U
M2_u0 d2 inp tail vss nfet L=0.13U W=1.6U
M2_u1 d2 inp tail vss nfet L=0.13U W=1.6U
Minput_pair_dummy0 vss vss vss vss nfet L=0.13U W=1.6U
Minput_pair_dummy1 vss vss vss vss nfet L=0.13U W=1.6U
M3_u0 d1 d1 vdd vdd pfet L=0.52U W=0.52U
M3_u1 d1 d1 vdd vdd pfet L=0.52U W=0.52U
M4_u0 d2 d1 vdd vdd pfet L=0.52U W=0.52U
M4_u1 d2 d1 vdd vdd pfet L=0.52U W=0.52U
Mmirror_dummy0 vdd vdd vdd vdd pfet L=0.52U W=0.52U
Mmirror_dummy1 vdd vdd vdd vdd pfet L=0.52U W=0.52U
M7_f0 out ibias vss vss nfet L=0.52U W=1.7U
M7_f1 out ibias vss vss nfet L=0.52U W=1.7U
M7_f2 out ibias vss vss nfet L=0.52U W=1.7U
M7_f3 out ibias vss vss nfet L=0.52U W=1.7U
M7_f4 out ibias vss vss nfet L=0.52U W=1.7U
M7_f5 out ibias vss vss nfet L=0.52U W=1.7U
M7_f6 out ibias vss vss nfet L=0.52U W=1.7U
M6_f0 out d2 vdd vdd pfet L=1.04U W=2.75U
M6_f1 out d2 vdd vdd pfet L=1.04U W=2.75U
M6_f2 out d2 vdd vdd pfet L=1.04U W=2.75U
M6_f3 out d2 vdd vdd pfet L=1.04U W=2.75U
M6_f4 out d2 vdd vdd pfet L=1.04U W=2.75U
M6_f5 out d2 vdd vdd pfet L=1.04U W=2.75U
M6_f6 out d2 vdd vdd pfet L=1.04U W=2.75U
M6_f7 out d2 vdd vdd pfet L=1.04U W=2.75U
M6_f8 out d2 vdd vdd pfet L=1.04U W=2.75U
M6_f9 out d2 vdd vdd pfet L=1.04U W=2.75U
M6_f10 out d2 vdd vdd pfet L=1.04U W=2.75U
M6_f11 out d2 vdd vdd pfet L=1.04U W=2.75U
Cc out d2 9.94847e-13 cap_cmim A=660.49P P=102.8U
.end
