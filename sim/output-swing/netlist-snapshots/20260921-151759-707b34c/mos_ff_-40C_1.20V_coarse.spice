* sg13g2-opamp -- DC output-swing bench, design/opamp_core.sch (issue #15)
* Generated from
* sim/output-swing/testbench/tb_swing.spice.tmpl by
* sim/output-swing/run_swing_sweep.sh -- do not edit a generated
* netlist-snapshots/*.spice file directly, edit this template and re-run
* the sweep.
*
* Point: corner=mos_ff temp_c=-40 vdd_v=1.20 pass=coarse
* Sweep: Vid from -0.1 V to 0.1 V, step 500e-6 V
* PDK: ihp-sg13g2 /Users/rwalters/share/pdk (see sim/pdk.json for the pinned release)
* OSDI models: /Users/rwalters/share/pdk/ihp-sg13g2/libs.tech/ngspice/osdi (built by sim/tools/build-osdi.sh)
* DUT netlist snapshot: /Users/rwalters/GitHub/sg13g2-opamp/.loom/worktrees/issue-15/sim/output-swing/netlist-snapshots/20260921-151759-707b34c/opamp_core.spice (frozen copy of
*   design/netlist/opamp_core.spice alongside this generated testbench, so
*   the exact DUT netlist this point ran against is reviewable later)
*
* ------------------------------------------------------------------ method
* design/netlist/opamp_core.spice is a FLAT xschem netlist (its
* "**.subckt"/"**.ends" lines are full-line SPICE comments, not an active
* subcircuit wrapper), so .include'ing it makes its own node names (vdd,
* vss, inn, inp, out, ibias, plus the internal d1/d2/tail nodes) live
* directly at this testbench's top level -- same convention as
* sim/open-loop-ac/ and sim/input-offset/. No "X..." instantiation is
* needed or used.
*
* WHAT IS MEASURED. Output swing is defined here, operationally, from the
* open-loop DC transfer curve: sweep the differential input
*
*     Vid = V(inp) - V(inn)
*
* with the input common-mode level pinned EXACTLY at Vcm = VDD/2 for every
* swept Vid:
*
*     V(inp) = Vcm + Vid/2      V(inn) = Vcm - Vid/2
*
* -- the same differential-drive convention as
* sim/input-offset/tb_offset_null.spice.tmpl, so the two benches bias and
* drive the same DUT the same way. The transfer curve Vout(Vid) is a
* monotonic saturating S-curve: hard-railed low for Vid far below the
* linear region, hard-railed high for Vid far above it, with a steep
* high-gain linear region in between. The rail-ward BOUNDARIES of that
* linear region are this bench's swing numbers: the maximum/minimum DC
* output voltage at which the amplifier still tracks its input (to the
* -6 dB incremental-gain criterion stated in README.md "The swing
* criterion" and applied by run_swing_sweep.sh post-processing), reported
* as headroom from VDD/VSS so the same record compares directly across
* the {1.08, 1.20, 1.32} V supply grid.
*
* WHY OPEN-LOOP, NOT A CLOSED-LOOP BUFFER SWEEP. A unity-gain buffer DC
* sweep (out wired to inn, ramp the input rail-to-rail) would understate
* this design's true output swing: the output feeds the INPUT pair's
* common mode, and this input pair's own common-mode range (it sits at
* Vcm = VDD/2 in every other bench in this tree) is NARROWER than the
* output stage's reach on at least the low rail -- the pair's tail node
* needs Vgs(M1) + Vov(M5) of headroom below the lowest usable input
* common mode, while the output stage's low-rail bounds is only the sink's
* single Vov(M7). Clipping a buffer therefore begins when the INPUT stage
* leaves its range, not when the output stage leaves its own. The
* open-loop differential sweep pins the input common mode at Vcm, where
* the input pair provably amplifies (recorded as passing per-point sanity
* points in sim/input-offset/ and sim/open-loop-ac/ at every grid point),
* so the measured bounds are set by the OUTPUT stage alone: M6 (PMOS
* output gain device, source=vdd, drain=out) bounds the high rail, M7
* (NMOS output current sink, drain=out, source=vss) bounds the low rail
* -- the two devices design/opamp_sizing.md's output-stage sections name.
*
* NO FEEDBACK IS USED HERE, deliberately (unlike sim/open-loop-ac/'s
* Lbreak DC-servo): the DC operating point of the standalone open-loop
* amplifier is ill-posed only in the sense that its output rails for any
* input away from the linear region -- which is precisely what a
* transfer-curve swing bench wants to see. No initial-condition or
* nodeset tricks are needed; each .dc point solves directly.
*
* RECORDED VECTORS (v(out)). run_swing_sweep.sh renders this
* template twice per grid point: a wide COARSE pass recording v(out)
* alone -- enough to locate the linear region's center (the single
* Vout = Vcm crossing, which is exactly sim/input-offset/'s offset number
* for this point) and to read both hard-clipped plateau levels -- and a
* FINE pass centered on the coarse crossing, recording v(out) plus
* i(vdd) so the supply current at the mid-swing operating point is
* committed evidence (cross-checked against sim/open-loop-ac/'s per-point
* Iq). Keeping the coarse pass single-vector is what bounds this
* experiment's corners/ footprint (see sim/input-offset/'s template for
* the same size-discipline note).
*
* ibias: a single external ideal 10 uA current source, per
* design/opamp_sizing.md "Bias scope" -- identical to sim/open-loop-ac/'s
* and sim/input-offset/'s treatment, so all benches bias the same DUT the
* same way.
*
* Cload is present (CL = 2e-12 F [DR-1]) purely so this bench's DUT
* environment matches sim/open-loop-ac/'s (the row this bench fills
* states its load); it has no effect on a DC analysis. No resistive load
* is attached -- see README.md "What this bench does not claim" for why
* that keeps this number an upper bound, not a loaded-swing number.

.lib "/Users/rwalters/share/pdk/ihp-sg13g2/libs.tech/ngspice/models/cornerCAP.lib" cap_typ
.include "/Users/rwalters/GitHub/sg13g2-opamp/.loom/worktrees/issue-15/sim/output-swing/netlist-snapshots/20260921-151759-707b34c/opamp_core.spice"

.lib "/Users/rwalters/share/pdk/ihp-sg13g2/libs.tech/ngspice/models/cornerMOSlv.lib" mos_ff

.options temp=-40 tnom=27

Vdd vdd 0 dc 1.20
Vss vss 0 dc 0
Iibias vdd ibias dc 10u
Vcm cm 0 dc 0.6
Vid id 0 dc 0
Binp inp 0 v = v(cm) + v(id)/2
Binn inn 0 v = v(cm) - v(id)/2
Cload out vss 2e-12

.control
pre_osdi /Users/rwalters/share/pdk/ihp-sg13g2/libs.tech/ngspice/osdi/psp103.osdi
pre_osdi /Users/rwalters/share/pdk/ihp-sg13g2/libs.tech/ngspice/osdi/psp103_nqs.osdi
pre_osdi /Users/rwalters/share/pdk/ihp-sg13g2/libs.tech/ngspice/osdi/mosvar.osdi
pre_osdi /Users/rwalters/share/pdk/ihp-sg13g2/libs.tech/ngspice/osdi/r3_cmc.osdi

dc Vid -0.1 0.1 500e-6
wrdata /Users/rwalters/GitHub/sg13g2-opamp/.loom/worktrees/issue-15/sim/output-swing/corners/20260921-151759-707b34c/mos_ff_-40C_1.20V_coarse.csv v(out)
.endc
.end
