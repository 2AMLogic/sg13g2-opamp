* SHARD BODY for mos_ff -- generated by sim/cmrr-psrr/klt/shard.py; do not edit.
* Deviations from tb_psrr.body.spice, all forced by the klt 0.5.0 fleet runner
* (2AMLogic/2am#2193), none changing the circuit or the measurement:
*  - .control pre_osdi + print-precision cards replace options.osdi_preload/ngspice_init;
*  - the DUT netlist is inlined in place of its .include (its .end line dropped);
*  - cornerCAP.lib cap_typ is selected by a body-level .lib card (the runner's
*    per-section corner libraries cannot carry the object form).
.control
pre_osdi /opt/pdk/ihp-sg13g2/libs.tech/ngspice/osdi/psp103.osdi
pre_osdi /opt/pdk/ihp-sg13g2/libs.tech/ngspice/osdi/psp103_nqs.osdi
pre_osdi /opt/pdk/ihp-sg13g2/libs.tech/ngspice/osdi/mosvar.osdi
pre_osdi /opt/pdk/ihp-sg13g2/libs.tech/ngspice/osdi/r3_cmc.osdi
set measureprec=12
set numdgt=12
.endc
* sg13g2-opamp -- PSRR (supply-gain) bench as a `klt sim` circuit body (issue #99)
*
* The SAME test circuit as ../testbench/tb_psrr.spice.tmpl (the harness path,
* sim/cmrr-psrr/run_cmrr_psrr_sweep.sh), re-expressed in the shape `klt sim`
* requires: a circuit body with no .control/.end of its own (klayout-tools
* docs/cli/sim.md, "Netlist convention"). klt generates the per-corner
* wrapper deck around this file and adds, per corner: the process `.lib`
* cards (cornerMOSlv.lib mos_<corner> plus cornerCAP.lib cap_typ), `.temp`,
* `alter vdd=<V>` and `alter vinp=<V/2>` (swept together by index, so
* Vcm = VDD/2 exactly as the harness's `vcm = vdd/2`), `pre_osdi` for the
* four OSDI libraries, and the one analysis the request declares
* (`ac dec 20 10m 1g` -- the template's own sweep).
*
* Element-for-element the template's circuit: flat DUT include (no X
* instance), Lbreak = 1e18 H from inn to out (DC loop break; open at AC),
* CL = 2 pF [DR-1], the 10 uA external ibias sunk from vdd (zero ac value, so
* supply ripple does not ride into the bias reference), Vss = ground.
*
* The excitation is the SUPPLY: Vdd carries `ac 1`, so vdb(out) IS the
* supply-to-output gain Avs(f) in dB. Vinp carries no ac value (input
* AC-quiet). The same source is both the swept supply (`alter vdd`) and the
* AC stimulus. Whether `alter vdd=<V>` preserves the `ac 1` magnitude is a
* property of the generated deck that the one-corner prototype must confirm
* (sim/cmrr-psrr/README.md, "The `klt sim` path"); it is not assumed.
*
* This body measures Avs ONLY. PSRR = Av0 / Avs needs the differential gain
* Av0 of the same point, a different AC excitation (Vinp ac 1, Vdd quiet);
* one AC solve cannot carry both, so compare.py joins Av0 offline from the
* committed open-loop harness record on (process, temperature, VDD) -- the
* very join the harness itself makes. See the README.
*
* No solver option is set (DR-0005: ngspice default tolerance).
*
* Exactly one .include, of the committed DUT netlist, by a path relative to
* this file (ngspice resolves a nested .include against the including file's
* directory; klt's off-host backends stage the same closure).

* ---- begin inlined design/netlist/opamp_core.spice ----
** sch_path: /Users/rwalters/GitHub/sg13g2-opamp/.loom/worktrees/issue-9/design/opamp_core.sch
**.subckt opamp_core vdd vss inn inp out ibias

*.iopin vdd
*.iopin vss
*.iopin inn
*.iopin inp
*.iopin out
*.iopin ibias
XM1 d1 inn tail vss sg13_lv_nmos w=3.2u l=0.13u ng=1 m=1
XM2 d2 inp tail vss sg13_lv_nmos w=3.2u l=0.13u ng=1 m=1
XM3 d1 d1 vdd vdd sg13_lv_pmos w=1.04u l=0.52u ng=1 m=1
XM4 d2 d1 vdd vdd sg13_lv_pmos w=1.04u l=0.52u ng=1 m=1
XM5 tail ibias vss vss sg13_lv_nmos w=2.2u l=0.52u ng=1 m=1
XMbias ibias ibias vss vss sg13_lv_nmos w=2.2u l=0.52u ng=1 m=1
XM6 out d2 vdd vdd sg13_lv_pmos w=33u l=1.04u ng=1 m=1
XM7 out ibias vss vss sg13_lv_nmos w=11.9u l=0.52u ng=1 m=1
XCc out d2 cap_cmim w=25.7u l=25.7u m=1
**.ends
* ---- end inlined design/netlist/opamp_core.spice ----
.lib "/opt/pdk/ihp-sg13g2/libs.tech/ngspice/models/cornerCAP.lib" cap_typ

.options tnom=27

Vdd vdd 0 dc 1.2 ac 1
Vss vss 0 dc 0
Iibias vdd ibias dc 10u
Vinp inp 0 dc 0.6
Lbreak inn out 1e18
Cload out vss 2e-12
