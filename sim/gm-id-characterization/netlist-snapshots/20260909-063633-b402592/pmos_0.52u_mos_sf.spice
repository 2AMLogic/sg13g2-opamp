* sg13g2-opamp -- gm/ID characterization sweep, sg13_lv_pmos (issue #5)
* Generated from sim/gm-id-characterization/testbench/tb_gmid_pmos.spice.tmpl
* by sim/gm-id-characterization/run_gmid_sweep.sh -- do not edit a generated
* netlist-snapshots/*.spice file directly, edit this template and re-run the
* sweep. Full methodology and rationale are in
* sim/gm-id-characterization/README.md; this header is a short pointer.
*
* Generated for: device=sg13_lv_pmos length=0.52u corner=mos_sf
* PDK: ihp-sg13g2 /Users/rwalters/share/pdk (see sim/pdk.json for the pinned release)
* OSDI models: /Users/rwalters/share/pdk/ihp-sg13g2/libs.tech/ngspice/osdi (built by sim/tools/build-osdi.sh)
*
* PMOS mirror of tb_gmid_nmos.spice.tmpl's method (see that file's header
* for the full DC/AC rationale) -- source and body tied to VDD=1.2V, drain
* and gate swept as absolute node voltages. The device's own Vsg = VDD-Vg
* and Vsd = VDD-Vd, so as the SWEPT Vg rises from 0.05V to 1.15V, the
* device's actual Vsg FALLS from 1.15V to 0.05V (strong to weak inversion,
* reverse order from the nmos template) -- the driver script re-expresses
* every row in terms of Vsg/Vsd before merging, so the two devices' output
* CSVs read the same way. Signs also flip relative to the nmos template:
* Id is read directly as +i(vd) (conventional current flows from source
* into the drain branch and out through Vd to ground, opposite polarity
* from the nmos case); gm = -d(Id)/d(Vg) = +d(Id)/d(Vsg); gds =
* -d(Id)/d(Vd) = +d(Id)/d(Vsd) (increasing swept Vd means DECREASING Vsd).
* Cgg's sign does not matter (extracted via abs()).

.lib "/Users/rwalters/share/pdk/ihp-sg13g2/libs.tech/ngspice/models/cornerMOSlv.lib" mos_sf

.options temp=27 tnom=27

Vdd vdd 0 dc 1.2
Vg g 0 dc 0.6 ac 1
Vd d 0 dc 0.6

Xdut d g vdd vdd sg13_lv_pmos w=10u l=0.52u ng=1 m=1

.control
pre_osdi /Users/rwalters/share/pdk/ihp-sg13g2/libs.tech/ngspice/osdi/psp103.osdi
pre_osdi /Users/rwalters/share/pdk/ihp-sg13g2/libs.tech/ngspice/osdi/psp103_nqs.osdi
pre_osdi /Users/rwalters/share/pdk/ihp-sg13g2/libs.tech/ngspice/osdi/mosvar.osdi
pre_osdi /Users/rwalters/share/pdk/ihp-sg13g2/libs.tech/ngspice/osdi/r3_cmc.osdi

* --- Pass 1: Id, gm, gds from a nested DC sweep. Sign conventions per the
* header comment above: Id = +i(vd); gm/gds are the NEGATIVE of the raw
* Vg/Vd derivatives (chain rule for Vsg=VDD-Vg, Vsd=VDD-Vd).
dc Vg 0.05 1.15 0.02 Vd 0.58 0.62 0.02
let ids_all = i(vd)
let vgs_all = v(g)
let ids_lo = ids_all[0,55]
let ids_mid = ids_all[56,111]
let ids_hi = ids_all[112,167]
let vgs = vgs_all[56,111]
let gm = -deriv(ids_mid)
let gds = -(ids_hi - ids_lo) / 0.04
wrdata /Users/rwalters/GitHub/sg13g2-opamp/.loom/worktrees/issue-5/sim/gm-id-characterization/corners/20260909-063633-b402592/pmos_0.52u_mos_sf_dc.csv vgs ids_mid gm gds

* --- Pass 2: Cgg from a single-frequency AC loop, one Vgs point at a time
* (see tb_gmid_nmos.spice.tmpl's header for why this cannot read back the
* dc1-plot vectors above once `ac` has run once).
let i = 0
dowhile i < 56
  let vgv = 0.05 + i*0.02
  echo "GMID_VGS $&vgv"
  alter Vg = $&vgv
  ac lin 1 10meg 10meg
  let ig = i(vg)
  let cval = abs(imag(ig)) / (2*3.14159265358979*10meg)
  echo "GMID_CGG $&cval"
  let i = i + 1
end
.endc
.end
