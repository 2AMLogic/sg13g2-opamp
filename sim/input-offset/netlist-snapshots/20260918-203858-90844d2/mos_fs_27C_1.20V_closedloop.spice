* sg13g2-opamp -- DC input-referred offset, closed-loop cross-check (issue #11)
* design/opamp_core.sch, deterministic/corner-only (no Monte Carlo).
* Generated from
* sim/input-offset/testbench/tb_offset_cl.spice.tmpl by
* sim/input-offset/run_offset_sweep.sh -- do not edit a generated
* netlist-snapshots/*.spice file directly, edit this template and re-run
* the sweep.
*
* Point: corner=mos_fs temp_c=27 vdd_v=1.20
* PDK: ihp-sg13g2 /Users/rwalters/share/pdk (see sim/pdk.json for the pinned release)
* OSDI models: /Users/rwalters/share/pdk/ihp-sg13g2/libs.tech/ngspice/osdi (built by sim/tools/build-osdi.sh)
* DUT netlist snapshot: /Users/rwalters/GitHub/sg13g2-opamp/.loom/worktrees/issue-11/sim/input-offset/netlist-snapshots/20260918-203858-90844d2/opamp_core.spice
*
* ------------------------------------------------------------------ method
* This is the SECOND of this experiment's two methods -- the cross-check,
* not the primary measurement (that is tb_offset_null.spice.tmpl). It is the
* "measure the closed-loop output DC error and refer it back through the
* measured DC gain" method named in issue #11, and it deliberately reuses
* sim/open-loop-ac/'s exact DC bias arrangement so that the two experiments'
* DC operating points are directly comparable:
*
*   Lbreak = 1e18 H from inn to out. An ideal inductor is a dead short at
*   DC, so this closes a unity-gain-buffer loop at DC (inn = out) while
*   inp is held at Vcm = VDD/2.
*
* With the amplifier's own DC transfer Vout = F(V(inp) - V(inn)) and the
* offset Vos defined (as in tb_offset_null.spice.tmpl) by F(Vos) = Vcm,
* linearizing about the null with small-signal gain Av gives
*
*   Vout = Vcm + Av*(Vcm - Vout - Vos)
*     =>  Vout - Vcm = -Vos * Av/(1 + Av)
*     =>  Vos = -(Vout - Vcm) * (1 + Av)/Av
*
* run_offset_sweep.sh evaluates that expression using the Av0 measured for
* the SAME corner/temperature/supply point by sim/open-loop-ac/ (that
* record's `av0_db` column) -- which is exactly the cross-referencing issue
* #11 asks for. The (1 + Av)/Av factor is a sub-1% correction at this
* design's ~38-45 dB DC gain, but it is applied rather than dropped so the
* two methods can be compared without an avoidable known bias between them.
*
* Note the one structural difference between the two methods, which is why
* they are expected to agree closely but not exactly: here the input
* common-mode level is (Vcm + Vout)/2 = Vcm - Vos/2 rather than exactly Vcm,
* because inn follows the output. That is a CMRR-order difference of half an
* offset (tens of microvolts of common-mode shift), documented in README.md
* "Two methods" rather than silently ignored.

.lib "/Users/rwalters/share/pdk/ihp-sg13g2/libs.tech/ngspice/models/cornerCAP.lib" cap_typ
.include "/Users/rwalters/GitHub/sg13g2-opamp/.loom/worktrees/issue-11/sim/input-offset/netlist-snapshots/20260918-203858-90844d2/opamp_core.spice"

.lib "/Users/rwalters/share/pdk/ihp-sg13g2/libs.tech/ngspice/models/cornerMOSlv.lib" mos_fs

.options temp=27 tnom=27

Vdd vdd 0 dc 1.20
Vss vss 0 dc 0
Iibias vdd ibias dc 10u
Vinp inp 0 dc 0.6
Lbreak inn out 1e18
Cload out vss 2e-12

.control
pre_osdi /Users/rwalters/share/pdk/ihp-sg13g2/libs.tech/ngspice/osdi/psp103.osdi
pre_osdi /Users/rwalters/share/pdk/ihp-sg13g2/libs.tech/ngspice/osdi/psp103_nqs.osdi
pre_osdi /Users/rwalters/share/pdk/ihp-sg13g2/libs.tech/ngspice/osdi/mosvar.osdi
pre_osdi /Users/rwalters/share/pdk/ihp-sg13g2/libs.tech/ngspice/osdi/r3_cmc.osdi

op
echo "CL_VOUT $&v(out)"
echo "CL_VD1 $&v(d1)"
echo "CL_VD2 $&v(d2)"
echo "CL_VTAIL $&v(tail)"
echo "CL_VIBIAS $&v(ibias)"
let ivdd_op = -i(vdd)
echo "CL_IVDD $&ivdd_op"
.endc
.end
