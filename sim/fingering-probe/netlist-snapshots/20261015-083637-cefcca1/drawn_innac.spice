* drawn_innac: drawn plus 'Cprobe_inn_acgnd inn vss 1' (inn AC-grounded; bench diagnostic).
* issue-#237 device-representation probe, variant 'drawn'.
* Nine instances, each with the drawn fingering (pairs m=units, folded ng=fingers).
* Written by sim/fingering-probe/build_probe_netlists.py -- DO NOT EDIT.
* Flat netlist (instantiated directly by the open-loop AC bench body).
XM5 tail ibias vss vss sg13_lv_nmos w=1.1u l=0.52u ng=1 m=2
XMbias ibias ibias vss vss sg13_lv_nmos w=1.1u l=0.52u ng=1 m=2
XM1 d1 inn tail vss sg13_lv_nmos w=1.6u l=0.13u ng=1 m=2
XM2 d2 inp tail vss sg13_lv_nmos w=1.6u l=0.13u ng=1 m=2
XM3 d1 d1 vdd vdd sg13_lv_pmos w=0.52u l=0.52u ng=1 m=2
XM4 d2 d1 vdd vdd sg13_lv_pmos w=0.52u l=0.52u ng=1 m=2
XM7 out ibias vss vss sg13_lv_nmos w=11.9u l=0.52u ng=7 m=1
XM6 out d2 vdd vdd sg13_lv_pmos w=33u l=1.04u ng=12 m=1
XCc out d2 cap_cmim w=25.7u l=25.7u m=1
Cprobe_inn_acgnd inn vss 1
.end
